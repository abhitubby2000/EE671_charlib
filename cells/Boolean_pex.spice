Boolean_pex.spice

* NGSPICE file created from Boolean.ext - technology: sky130A

X0 ~B1 B1 VSS VSS sky130_fd_pr__nfet_01v8 ad=0.126 pd=1.44 as=0.126 ps=1.44 w=0.42 l=0.15
X1 ~B1 B1 VDD VDD sky130_fd_pr__pfet_01v8 ad=0.405 pd=3.3 as=0.35258 ps=2.93675 w=1.35 l=0.15
X2 a_94_101# A1 Y VSS sky130_fd_pr__nfet_01v8 ad=0.105 pd=1.2 as=0.063 ps=0.72 w=0.42 l=0.15
X3 Y ~B1 VDD VDD sky130_fd_pr__pfet_01v8 ad=0.16725 pd=1.415 as=0.2912 ps=2.42554 w=1.115 l=0.15
X4 Y A1 a_94_101# VSS sky130_fd_pr__nfet_01v8 ad=0.063 pd=0.72 as=0.105 ps=1.2 w=0.42 l=0.15
X5 VDD A1 a_184_292# VDD sky130_fd_pr__pfet_01v8 ad=0.2912 pd=2.42554 as=0.21046 ps=1.77125 w=1.115 l=0.15
X6 a_184_292# A1 VDD VDD sky130_fd_pr__pfet_01v8 ad=0.21046 pd=1.77125 as=0.2912 ps=2.42554 w=1.115 l=0.15
X7 Y A2 a_184_292# VDD sky130_fd_pr__pfet_01v8 ad=0.16725 pd=1.415 as=0.21046 ps=1.77125 w=1.115 l=0.15
X8 a_184_292# A2 Y VDD sky130_fd_pr__pfet_01v8 ad=0.21046 pd=1.77125 as=0.16725 ps=1.415 w=1.115 l=0.15
X9 VDD A1 a_184_292# VDD sky130_fd_pr__pfet_01v8 ad=0.2912 pd=2.42554 as=0.21046 ps=1.77125 w=1.115 l=0.15
X10 a_184_292# A1 VDD VDD sky130_fd_pr__pfet_01v8 ad=0.21046 pd=1.77125 as=0.2912 ps=2.42554 w=1.115 l=0.15
X11 VSS ~B1 a_94_101# VSS sky130_fd_pr__nfet_01v8 ad=0.126 pd=1.44 as=0.105 ps=1.2 w=0.42 l=0.15
X12 VDD ~B1 Y VDD sky130_fd_pr__pfet_01v8 ad=0.2912 pd=2.42554 as=0.16725 ps=1.415 w=1.115 l=0.15
X13 a_94_101# A2 Y VSS sky130_fd_pr__nfet_01v8 ad=0.105 pd=1.2 as=0.063 ps=0.72 w=0.42 l=0.15
X14 Y A2 a_94_101# VSS sky130_fd_pr__nfet_01v8 ad=0.063 pd=0.72 as=0.105 ps=1.2 w=0.42 l=0.15
X15 a_184_292# A2 Y VDD sky130_fd_pr__pfet_01v8 ad=0.21046 pd=1.77125 as=0.16725 ps=1.415 w=1.115 l=0.15
X16 Y A2 a_184_292# VDD sky130_fd_pr__pfet_01v8 ad=0.16725 pd=1.415 as=0.21046 ps=1.77125 w=1.115 l=0.15
X17 a_94_101# ~B1 VSS VSS sky130_fd_pr__nfet_01v8 ad=0.105 pd=1.2 as=0.126 ps=1.44 w=0.42 l=0.15
C0 a_94_101# a_184_292# 0.13067f
C1 A2 a_94_101# 0.07438f
C2 B1 m1_865_110# 0
C3 A2 a_184_292# 0.10447f
C4 VDD B1 0.15597f
C5 Y m1_865_110# 0.01601f
C6 ~B1 B1 0.04075f
C7 VDD Y 1.36134f
C8 A1 Y 0.06879f
C9 ~B1 Y 0.09596f
C10 m1_193_109# a_94_101# 0.06606f
C11 m1_193_109# a_184_292# 0.01642f
C12 A2 m1_193_109# 0
C13 B1 a_94_101# 0.03519f
C14 B1 a_184_292# 0
C15 A2 B1 0.00993f
C16 Y a_94_101# 0.47737f
C17 Y a_184_292# 0.76075f
C18 A2 Y 0.2089f
C19 VDD A1 0.28175f
C20 ~B1 VDD 0.45905f
C21 Y m1_193_109# 0.01834f
C22 m1_865_110# a_94_101# 0.09728f
C23 m1_865_110# a_184_292# 0.00182f
C24 VDD a_94_101# 0.43309f
C25 A1 a_94_101# 0.05187f
C26 A2 m1_865_110# 0.00252f
C27 ~B1 a_94_101# 0.08026f
C28 VDD a_184_292# 1.85299f
C29 A1 a_184_292# 0.09256f
C30 Y B1 0.01376f
C31 ~B1 a_184_292# 0
C32 A2 VDD 0.20507f
C33 A2 A1 0.01214f
C34 A2 ~B1 0
C35 VDD m1_193_109# 0
C36 A1 m1_193_109# 0.00283f
C37 Y VSS 0.71268f
C38 A2 VSS 0.42439f
C39 A1 VSS 0.51723f
C40 m1_865_110# VSS 0.03161f ; **FLOATING
C41 m1_193_109# VSS 0.02936f ; **FLOATING
C42 a_94_101# VSS 1.47423f
C43 a_184_292# VSS 0.41015f
C44 ~B1 VSS 0.58586f
C45 B1 VSS 0.34159f
C46 VDD VSS 3.15335f
